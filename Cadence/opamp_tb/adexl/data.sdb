ADE simulation setup
Run mode: Single Run, Sweeps and Corners
Tests:
  p_ac_gain: integrated_systems_first/opamp_tb/schematic, simulator spectre
    Outputs: phase(VF("/vout"))
  np_ac_gain: integrated_systems_first/opamp_tb/schematic, simulator spectre
    Outputs: phase(VF("/vout"))
  np_dc_op (off): integrated_systems_first/opamp_tb/schematic, simulator spectre
    Outputs: /vout
  np_cm_gain (off): integrated_systems_first/opamp_tb/schematic, simulator spectre
    Outputs: /vout
  p_cm_gain (off): integrated_systems_first/opamp_tb/schematic, simulator spectre
    Outputs: /vout
Global variables:
  iac = 0
  vcm = 1.6
  vd = 0 (off)
  VDD = 3.2
  VSS = 0
  Lout_p = 0.35u
  Wout_p = 10u
  Lout_n = 2.76u
  Wout_n = 5.75u
  Ldp_p = 0.35u
  Wdp_p = 27.66u
  Ldp_n = 2.76u
  Wdp_n = 5.75u
  Rbias = 2e3
  VCM = (VDD - VSS) / 2
  vacm = 0 (off)
